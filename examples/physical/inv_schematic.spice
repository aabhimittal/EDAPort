* reference inverter (schematic side)
.subckt inv A Y VDD VSS
M1 Y A VDD VDD pmos W=1u L=0.15u
M2 Y A VSS VSS nmos W=0.5u L=0.15u
.ends
